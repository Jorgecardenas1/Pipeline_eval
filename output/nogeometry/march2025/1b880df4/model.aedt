# Ansys Electronics Desktop project, version 2023.2
materials:
  vacuum: permittivity=1
  Rogers RT/duroid 5880 (tm): permittivity=2.2 dielectric_loss_tangent=0.0009
  pec: conductivity=1e+30
  copper: permeability=0.999991 conductivity=58000000

design HFSSDesign1 (HFSS, HFSS Modal Network, model units mm)
variables:
  Xsize = 5mm
  Ysize = 5mm
  H = 0.508mm
geometry:
  Region [vacuum] = region(absolute_offset: +X=0mm, -X=0mm, +Y=0mm, -Y=0mm, +Z=10mm, -Z=10mm)
  conductor_1, conductor_1209, conductor_2252 = imported_body(C:/Users/jorge/AppData/Local/Temp/2F7E1822817422697693..x_t)
  substrate_4510 [Rogers RT/duroid 5880 (tm)] = imported_body(C:/Users/jorge/AppData/Local/Temp/2F7E1822817422697693..x_t)
  substrate_4511 = imported_body(C:/Users/jorge/AppData/Local/Temp/2F7E1822817422697693..x_t)
  substrate_4510.thicken(0.508mm)
  Rectangle1 = rectangle(corner=(2.4580645mm, -1.1785508mm, 0.508mm), x_size=0.041935523mm, y_size=-0.3214492mm)
  conductor_2252.subtract(Rectangle1)
boundaries and excitations:
  Primary1: Primary Faces=Region.face(+x) CoordSysVector{(4.9355918, -4.9355918, 10.508) -> (4.9355918, 0.00025, 10.508)}
  Primary2: Primary Faces=Region.face(+y) CoordSysVector{(4.9355918, 0.00025, 10.508) -> (-0.00025, 0.00025, 10.508)}
  Secondary1: Secondary Faces=Region.face(-y) CoordSysVector{(4.9355918, -4.9355918, 10.508) -> (-0.00025, -4.9355918, 10.508)} ReverseV primary=Primary2 PhaseDelay=UseScanAngle Phi=0deg Theta=0deg
  Secondary2: Secondary Faces=Region.face(-x) CoordSysVector{(-0.00025, -4.9355918, 10.508) -> (-0.00025, 0.00025, 10.508)} ReverseV primary=Primary1 PhaseDelay=UseScanAngle Phi=0deg Theta=0deg
  PerfE1: Perfect E Objects=substrate_4511
  PerfE2: Perfect E Objects=[conductor_1, conductor_1209, conductor_2252]
  FloquetPort1: Floquet Port Faces=Region.face(+z) NumModes=2 DeembedDist=10mm Modes{Mode1{CharImp=Zpi} Mode2{CharImp=Zpi}} PhaseDelay=UseScanAngle Phi=0deg Theta=0deg LatticeAVector{(4.9355918, -4.9355918, 10.508) -> (4.9355918, 0.00025, 10.508)} LatticeBVector{(4.9355918, -4.9355918, 10.508) -> (-0.00025, -4.9355918, 10.508)} ModesList{Mode{ModeNumber=1 IndexM=0 IndexN=0 KC2=0 PropagationState=Propagating Attenuation=0 PolarizationState=TE AffectsRefinement} Mode{ModeNumber=2 IndexM=0 IndexN=0 KC2=0 PropagationState=Propagating Attenuation=0 PolarizationState=TM AffectsRefinement}}
  FloquetPort2: Floquet Port Faces=Region.face(-z) NumModes=2 DeembedDist=10mm Modes{Mode1{CharImp=Zpi} Mode2{CharImp=Zpi}} PhaseDelay=UseScanAngle Phi=0deg Theta=0deg LatticeAVector{(4.9355918, -4.9355918, -10) -> (4.9355918, 0.00025, -10)} LatticeBVector{(4.9355918, -4.9355918, -10) -> (-0.00025, -4.9355918, -10)} ModesList{Mode{ModeNumber=1 IndexM=0 IndexN=0 KC2=0 PropagationState=Propagating Attenuation=0 PolarizationState=TE AffectsRefinement} Mode{ModeNumber=2 IndexM=0 IndexN=0 KC2=0 PropagationState=Propagating Attenuation=0 PolarizationState=TM AffectsRefinement}}
mesh:
  initial mesh: GlobalSurfApproximation{CurvedSurfaceApproxChoice=UseSlider SliderMeshSettings=3} GlobalModelRes{DefeatureLength=0.08mm} DynamicSurfaceResolution
setups:
  Setup1: HfssDriven Frequency=76.5GHz MaxDeltaS=0.02 MaximumPasses=10 MinimumPasses=3 MinimumConvergedPasses=2 PercentRefinement=30 BasisOrder=1 PortAccuracy=2 DrivenSolverType="Direct Solver"
    sweep Sweep: 75GHz to 78GHz step 0.03GHz; Type=Interpolating InterpTolerance=0.5 InterpMaxSolns=250 InterpUsePortImped=false PassivityErrorTolerance=0.0001
source amplitudes:
  FloquetPort1:1: 1W 0deg
  FloquetPort1:2, FloquetPort2:1, FloquetPort2:2: 0W 0deg
output variables:
  transmittance = (mag(S(FloquetPort2:1,FloquetPort1:1)))^2
  transmittanceTM = (mag(S(FloquetPort2:2,FloquetPort1:2)))^2
  ReflectanceTE = (mag(S(FloquetPort1:1,FloquetPort1:1)))^2
  ReflectanceTM = (mag(S(FloquetPort1:2,FloquetPort1:2)))^2
  AbsorbanceTE = 1-((mag(S(FloquetPort1:1,FloquetPort1:1)))^2 +(mag(S(FloquetPort2:1,FloquetPort1:1)))^2)
  AbsorbanceTM = 1-((mag(S(FloquetPort1:2,FloquetPort1:2)))^2 +(mag(S(FloquetPort2:2,FloquetPort1:2)))^2)
reports:
  Reflectance: ReflectanceTE, ReflectanceTM vs Freq on Setup1 : Sweep
  Absorption: AbsorbanceTM, AbsorbanceTE vs Freq on Setup1 : Sweep
