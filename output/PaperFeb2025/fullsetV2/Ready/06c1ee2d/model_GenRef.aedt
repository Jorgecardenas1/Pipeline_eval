# Ansys Electronics Desktop project, version 2023.2
materials:
  vacuum: permittivity=1
  Rogers RT/duroid 5880 (tm): permittivity=2.2 dielectric_loss_tangent=0.0009
  pec: conductivity=1e+30
  copper: permeability=0.999991 conductivity=58000000

design HFSSDesign1 (HFSS, HFSS Modal Network, model units mm)
variables:
  Xsize = 5mm
  Ysize = 5mm
  H = 0.508mm
  angle = 15deg
geometry:
  Region [vacuum] = region(absolute_offset: +X=0mm, -X=0mm, +Y=0mm, -Y=0mm, +Z=10mm, -Z=10mm)
  conductor_1 [copper] = imported_body(C:/Users/jorge/AppData/Local/Temp/5F701428817414507103..x_t)
  conductor_2 = imported_body(C:/Users/jorge/AppData/Local/Temp/5F701428817414507103..x_t)
  conductor_1.subtract(conductor_2)
  conductor_1.thicken(0.035mm)
  conductor_3 [copper] = imported_body(C:/Users/jorge/AppData/Local/Temp/5F701428817414507103..x_t)
  conductor_3.thicken(0.035mm)
  substrate_5 [Rogers RT/duroid 5880 (tm)] = imported_body(C:/Users/jorge/AppData/Local/Temp/5F701428817414507103..x_t)
  substrate_5.thicken(0.508mm)
  substrate_6 = imported_body(C:/Users/jorge/AppData/Local/Temp/5F701428817414507103..x_t)
  [conductor_1, conductor_3, substrate_5, substrate_6].move(0mm, 5.0166836mm, 0mm)
boundaries and excitations:
  Primary1: Primary Faces=Region.face(+x) CoordSysVector{(5.0164336, 0.00025, 10.543) -> (5.0164336, 5.0169336, 10.543)}
  Primary2: Primary Faces=Region.face(+y) CoordSysVector{(5.0164336, 5.0169336, 10.543) -> (-0.00025, 5.0169336, 10.543)}
  Secondary1: Secondary Faces=Region.face(-y) CoordSysVector{(5.0164336, 0.00025, 10.543) -> (-0.00025, 0.00025, 10.543)} ReverseV primary=Primary2 PhaseDelay=UseScanAngle Phi=0deg Theta=angle
  Secondary2: Secondary Faces=Region.face(-x) CoordSysVector{(-0.00025, 0.00025, 10.543) -> (-0.00025, 5.0169336, 10.543)} ReverseV primary=Primary1 PhaseDelay=UseScanAngle Phi=0deg Theta=angle
  PerfE1: Perfect E Objects=substrate_6
  FloquetPort1: Floquet Port Faces=Region.face(+z) NumModes=2 DeembedDist=10mm Modes{Mode1{CharImp=Zpi} Mode2{CharImp=Zpi}} PhaseDelay=UseScanAngle Phi=0deg Theta=angle LatticeAVector{(5.0164336, 0.00025, 10.543) -> (5.0164336, 5.0169336, 10.543)} LatticeBVector{(5.0164336, 0.00025, 10.543) -> (-0.00025, 0.00025, 10.543)} ModesList{Mode{ModeNumber=1 IndexM=0 IndexN=0 KC2=0 PropagationState=Propagating Attenuation=0 PolarizationState=TE AffectsRefinement} Mode{ModeNumber=2 IndexM=0 IndexN=0 KC2=0 PropagationState=Propagating Attenuation=0 PolarizationState=TM AffectsRefinement}}
  FloquetPort2: Floquet Port Faces=Region.face(-z) NumModes=2 DeembedDist=10mm Modes{Mode1{CharImp=Zpi} Mode2{CharImp=Zpi}} PhaseDelay=UseScanAngle Phi=0deg Theta=angle LatticeAVector{(5.0164336, 0.00025, -10) -> (5.0164336, 5.0169336, -10)} LatticeBVector{(5.0164336, 0.00025, -10) -> (-0.00025, 0.00025, -10)} ModesList{Mode{ModeNumber=1 IndexM=0 IndexN=0 KC2=0 PropagationState=Propagating Attenuation=0 PolarizationState=TE AffectsRefinement} Mode{ModeNumber=2 IndexM=0 IndexN=0 KC2=0 PropagationState=Propagating Attenuation=0 PolarizationState=TM AffectsRefinement}}
mesh:
  initial mesh: GlobalSurfApproximation{CurvedSurfaceApproxChoice=UseSlider SliderMeshSettings=3} GlobalModelRes{DefeatureLength=0.08mm} DynamicSurfaceResolution
setups:
  Setup1: HfssDriven Frequency=76.5GHz MaxDeltaS=0.02 MaximumPasses=10 MinimumPasses=3 MinimumConvergedPasses=2 PercentRefinement=30 BasisOrder=1 PortAccuracy=2 DrivenSolverType="Direct Solver"
    sweep Sweep: 75GHz to 78GHz step 0.03GHz; Type=Interpolating InterpTolerance=0.5 InterpMaxSolns=250 InterpUsePortImped=false PassivityErrorTolerance=0.0001
source amplitudes:
  FloquetPort1:1: 1W 0deg
  FloquetPort1:2, FloquetPort2:1, FloquetPort2:2: 0W 0deg
optimetrics:
  ParametricSetup1: Parametric Sim._Setups=[Setup1]
    sweep angle: LIN 0deg 40deg 10deg
output variables:
  transmittance = (mag(S(FloquetPort2:1,FloquetPort1:1)))^2
  transmittanceTM = (mag(S(FloquetPort2:2,FloquetPort1:2)))^2
  ReflectanceTE = (mag(S(FloquetPort1:1,FloquetPort1:1)))^2
  ReflectanceTM = (mag(S(FloquetPort1:2,FloquetPort1:2)))^2
  AbsorbanceTE = 1-((mag(S(FloquetPort1:1,FloquetPort1:1)))^2 +(mag(S(FloquetPort2:1,FloquetPort1:1)))^2)
  AbsorbanceTM = 1-((mag(S(FloquetPort1:2,FloquetPort1:2)))^2 +(mag(S(FloquetPort2:2,FloquetPort1:2)))^2)
reports:
  Reflectance: ReflectanceTE, ReflectanceTM vs Freq on Setup1 : Sweep
  AbsorptionGen_angle: AbsorbanceTE, AbsorbanceTM vs Freq on Setup1 : Sweep [angle=all]

design HFSSDesign3 (HFSS, HFSS Modal Network, model units mm)
variables:
  margin = 1mm
  wArm = 1.2mm
  lArm = 3.52mm
  angle = 40deg
  factor = 1
  parameters = [0.247, 0.1, 0.05, 0.035, 0.508, 5.007] mm
  Xsize = parameters[5]
  Ysize = parameters[5]
  radius = parameters[0]
  thick = parameters[2]
  sep = parameters[1]
  cellSize = parameters[5]
  H = parameters[4]
geometry:
  Region [vacuum] = region(absolute_offset: +X=0mm, -X=0mm, +Y=0mm, -Y=0mm, +Z=10mm, -Z=10mm)
  Rectangle1 = rectangle(corner=(0mm, 0mm, 0mm), x_size=Xsize, y_size=Ysize)
  Box1 [Rogers RT/duroid 5880 (tm)] = box(corner=(0mm, 0mm, 0mm), size=(Xsize, Ysize, H))
  Cylinder1 [copper] = cylinder(axis=Z, base_centre=(Xsize/2, Ysize/2, H), radius=radius, height=0.035mm)
  Cylinder2 [copper] = cylinder(axis=Z, base_centre=(Xsize/2, Ysize/2, H), radius=(radius+sep+thick)*factor, height=0.035mm)
  Cylinder3 = cylinder(axis=Z, base_centre=(Xsize/2, Ysize/2, H), radius=(radius+sep)*factor, height=0.035mm)
  Cylinder2.subtract(Cylinder3)
boundaries and excitations:
  Primary1: Primary Faces=Region.face(+x) CoordSysVector{(5.007, 0, 10.543) -> (5.007, 5.007, 10.543)}
  Primary2: Primary Faces=Region.face(+y) CoordSysVector{(5.007, 5.007, 10.543) -> (0, 5.007, 10.543)}
  Secondary1: Secondary Faces=Region.face(-y) CoordSysVector{(5.007, 0, 10.543) -> (0, 0, 10.543)} ReverseV primary=Primary2 PhaseDelay=UseScanAngle Phi=0deg Theta=angle
  Secondary2: Secondary Faces=Region.face(-x) CoordSysVector{(0, 0, 10.543) -> (0, 5.007, 10.543)} ReverseV primary=Primary1 PhaseDelay=UseScanAngle Phi=0deg Theta=angle
  PerfE1: Perfect E Objects=Rectangle1
  FloquetPort1: Floquet Port Faces=Region.face(+z) NumModes=2 DeembedDist=10mm Modes{Mode1{CharImp=Zpi} Mode2{CharImp=Zpi}} PhaseDelay=UseScanAngle Phi=0deg Theta=angle LatticeAVector{(5.007, 0, 10.543) -> (5.007, 5.007, 10.543)} LatticeBVector{(5.007, 0, 10.543) -> (0, 0, 10.543)} ModesList{Mode{ModeNumber=1 IndexM=0 IndexN=0 KC2=0 PropagationState=Propagating Attenuation=0 PolarizationState=TE AffectsRefinement} Mode{ModeNumber=2 IndexM=0 IndexN=0 KC2=0 PropagationState=Propagating Attenuation=0 PolarizationState=TM AffectsRefinement}}
  FloquetPort2: Floquet Port Faces=Region.face(-z) NumModes=2 DeembedDist=10mm Modes{Mode1{CharImp=Zpi} Mode2{CharImp=Zpi}} PhaseDelay=UseScanAngle Phi=0deg Theta=angle LatticeAVector{(5.007, 0, -10) -> (5.007, 5.007, -10)} LatticeBVector{(5.007, 0, -10) -> (0, 0, -10)} ModesList{Mode{ModeNumber=1 IndexM=0 IndexN=0 KC2=0 PropagationState=Propagating Attenuation=0 PolarizationState=TE AffectsRefinement} Mode{ModeNumber=2 IndexM=0 IndexN=0 KC2=0 PropagationState=Propagating Attenuation=0 PolarizationState=TM AffectsRefinement}}
setups:
  Setup1: HfssDriven Frequency=76.5GHz MaxDeltaS=0.02 MaximumPasses=5 MinimumPasses=1 MinimumConvergedPasses=1 PercentRefinement=30 BasisOrder=1 PortAccuracy=2 DrivenSolverType="Direct Solver"
    sweep Sweep: 75GHz to 78GHz step 0.03GHz; Type=Interpolating InterpTolerance=0.5 InterpMaxSolns=250 InterpUsePortImped=false PassivityErrorTolerance=0.0001
source amplitudes:
  FloquetPort1:1: 1W 0deg
  FloquetPort1:2, FloquetPort2:1, FloquetPort2:2: 0W 0deg
optimetrics:
  ParametricSetup1: Parametric Sim._Setups=[Setup1]
    sweep angle: LIN 0deg 40deg 10deg
output variables:
  AbsorbanceTE = 1-((mag(S(FloquetPort1:1,FloquetPort1:1)))^2 +(mag(S(FloquetPort2:1,FloquetPort1:1)))^2)
  AbsorbanceTM = 1-((mag(S(FloquetPort1:2,FloquetPort1:2)))^2 +(mag(S(FloquetPort2:2,FloquetPort1:2)))^2)
  Reflectance = (mag(S(FloquetPort1:1,FloquetPort1:1)))^2
reports:
  AbsorptionRef_angle: AbsorbanceTE, AbsorbanceTM vs Freq on Setup1 : Sweep [angle=all]
