# Ansys Electronics Desktop project, version 2023.2
materials:
  vacuum: permittivity=1
  Rogers RT/duroid 5880 (tm): permittivity=2.2 dielectric_loss_tangent=0.0009
  pec: conductivity=1e+30
  copper: permeability=0.999991 conductivity=58000000

design HFSSDesign1 (HFSS, HFSS Modal Network, model units mm)
variables:
  Xsize = 5mm
  Ysize = 5mm
  H = 0.508mm
  angle = 0deg
geometry:
  Region [vacuum] = region(absolute_offset: +X=0mm, -X=0mm, +Y=0mm, -Y=0mm, +Z=10mm, -Z=10mm)
  conductor_1 [copper] = imported_body(C:/Users/jorge/AppData/Local/Temp/3288166017413669153..x_t)
  conductor_1.thicken(0.035mm)
  substrate_6 [Rogers RT/duroid 5880 (tm)] = imported_body(C:/Users/jorge/AppData/Local/Temp/3288166017413669153..x_t)
  substrate_6.thicken(0.508mm)
  substrate_7 = imported_body(C:/Users/jorge/AppData/Local/Temp/3288166017413669153..x_t)
  [conductor_1, substrate_6, substrate_7].move(0mm, 4.8939238mm, 0mm)
boundaries and excitations:
  Primary1: Primary Faces=Region.face(+x) CoordSysVector{(4.8936738, 0.00025, 10.543) -> (4.8936738, 4.8941738, 10.543)}
  Primary2: Primary Faces=Region.face(+y) CoordSysVector{(4.8936738, 4.8941738, 10.543) -> (-0.00025, 4.8941738, 10.543)}
  Secondary1: Secondary Faces=Region.face(-y) CoordSysVector{(4.8936738, 0.00025, 10.543) -> (-0.00025, 0.00025, 10.543)} ReverseV primary=Primary2 PhaseDelay=UseScanAngle Phi=0deg Theta=angle
  Secondary2: Secondary Faces=Region.face(-x) CoordSysVector{(-0.00025, 0.00025, 10.543) -> (-0.00025, 4.8941738, 10.543)} ReverseV primary=Primary1 PhaseDelay=UseScanAngle Phi=0deg Theta=angle
  PerfE1: Perfect E Objects=substrate_7
  FloquetPort1: Floquet Port Faces=Region.face(+z) NumModes=2 DeembedDist=10mm Modes{Mode1{CharImp=Zpi} Mode2{CharImp=Zpi}} PhaseDelay=UseScanAngle Phi=0deg Theta=angle LatticeAVector{(4.8936738, 0.00025, 10.543) -> (4.8936738, 4.8941738, 10.543)} LatticeBVector{(4.8936738, 0.00025, 10.543) -> (-0.00025, 0.00025, 10.543)} ModesList{Mode{ModeNumber=1 IndexM=0 IndexN=0 KC2=0 PropagationState=Propagating Attenuation=0 PolarizationState=TE AffectsRefinement} Mode{ModeNumber=2 IndexM=0 IndexN=0 KC2=0 PropagationState=Propagating Attenuation=0 PolarizationState=TM AffectsRefinement}}
  FloquetPort2: Floquet Port Faces=Region.face(-z) NumModes=2 DeembedDist=10mm Modes{Mode1{CharImp=Zpi} Mode2{CharImp=Zpi}} PhaseDelay=UseScanAngle Phi=0deg Theta=angle LatticeAVector{(4.8936738, 0.00025, -10) -> (4.8936738, 4.8941738, -10)} LatticeBVector{(4.8936738, 0.00025, -10) -> (-0.00025, 0.00025, -10)} ModesList{Mode{ModeNumber=1 IndexM=0 IndexN=0 KC2=0 PropagationState=Propagating Attenuation=0 PolarizationState=TE AffectsRefinement} Mode{ModeNumber=2 IndexM=0 IndexN=0 KC2=0 PropagationState=Propagating Attenuation=0 PolarizationState=TM AffectsRefinement}}
mesh:
  initial mesh: GlobalSurfApproximation{CurvedSurfaceApproxChoice=UseSlider SliderMeshSettings=3} GlobalModelRes{DefeatureLength=0.08mm} DynamicSurfaceResolution
setups:
  Setup1: HfssDriven Frequency=76.5GHz MaxDeltaS=0.02 MaximumPasses=10 MinimumPasses=3 MinimumConvergedPasses=2 PercentRefinement=30 BasisOrder=1 PortAccuracy=2 DrivenSolverType="Direct Solver"
    sweep Sweep: 75GHz to 78GHz step 0.03GHz; Type=Interpolating InterpTolerance=0.5 InterpMaxSolns=250 InterpUsePortImped=false PassivityErrorTolerance=0.0001
source amplitudes:
  FloquetPort1:1: 1W 0deg
  FloquetPort1:2, FloquetPort2:1, FloquetPort2:2: 0W 0deg
optimetrics:
  ParametricSetup1: Parametric Sim._Setups=[Setup1]
    sweep angle: LIN 0deg 40deg 10deg
output variables:
  transmittance = (mag(S(FloquetPort2:1,FloquetPort1:1)))^2
  transmittanceTM = (mag(S(FloquetPort2:2,FloquetPort1:2)))^2
  ReflectanceTE = (mag(S(FloquetPort1:1,FloquetPort1:1)))^2
  ReflectanceTM = (mag(S(FloquetPort1:2,FloquetPort1:2)))^2
  AbsorbanceTE = 1-((mag(S(FloquetPort1:1,FloquetPort1:1)))^2 +(mag(S(FloquetPort2:1,FloquetPort1:1)))^2)
  AbsorbanceTM = 1-((mag(S(FloquetPort1:2,FloquetPort1:2)))^2 +(mag(S(FloquetPort2:2,FloquetPort1:2)))^2)
reports:
  Reflectance: ReflectanceTE, ReflectanceTM vs Freq on Setup1 : Sweep
  AbsorptionGen_angle: AbsorbanceTE, AbsorbanceTM vs Freq on Setup1 : Sweep [angle=30deg]; markers MX1 at x=7.7579268e+10
  AbsorptionGen_angle_1: AbsorbanceTE, AbsorbanceTM vs Freq on Setup1 : Sweep [angle=all]; markers MX1 at x=7.5417683e+10

design HFSSDesign2 (HFSS, HFSS Modal Network, model units mm)
variables:
  Xsize = 5mm
  Ysize = 5mm
  H = 0.508mm
  margin = 1mm
  radius = 0.365mm
  angle = 20deg
  parameters = [0.403, 0.035, 0.508, 4.895] mm
geometry:
  Rectangle1 = rectangle(corner=(0mm, 0mm, 0mm), x_size=parameters[3], y_size=parameters[3])
  Box1 [Rogers RT/duroid 5880 (tm)] = box(corner=(0mm, 0mm, 0mm), size=(parameters[3], parameters[3], parameters[2]))
  Cylinder1 [copper] = cylinder(axis=Z, base_centre=(parameters[3]/2, parameters[3]/2, H), radius=parameters[0], height=parameters[1])
  Region [vacuum] = region(absolute_offset: +X=0mm, -X=0mm, +Y=0mm, -Y=0mm, +Z=10mm, -Z=10mm)
boundaries and excitations:
  PerfE1: Perfect E Objects=Rectangle1
  Primary1: Primary Faces=Region.face(+x) CoordSysVector{(4.895, 0, 10.543) -> (4.895, 4.895, 10.543)}
  Primary2: Primary Faces=Region.face(+y) CoordSysVector{(4.895, 4.895, 10.543) -> (0, 4.895, 10.543)}
  Secondary1: Secondary Faces=Region.face(-y) CoordSysVector{(4.895, 0, 10.543) -> (0, 0, 10.543)} ReverseV primary=Primary2 PhaseDelay=UseScanAngle Phi=0deg Theta=angle
  Secondary2: Secondary Faces=Region.face(-x) CoordSysVector{(0, 0, 10.543) -> (0, 4.895, 10.543)} ReverseV primary=Primary1 PhaseDelay=UseScanAngle Phi=0deg Theta=angle
  FloquetPort1: Floquet Port Faces=Region.face(+z) NumModes=2 DeembedDist=10mm Modes{Mode1{CharImp=Zpi} Mode2{CharImp=Zpi}} PhaseDelay=UseScanAngle Phi=0deg Theta=angle LatticeAVector{(4.895, 0, 10.543) -> (4.895, 4.895, 10.543)} LatticeBVector{(4.895, 0, 10.543) -> (0, 0, 10.543)} ModesList{Mode{ModeNumber=1 IndexM=0 IndexN=0 KC2=0 PropagationState=Propagating Attenuation=0 PolarizationState=TE AffectsRefinement} Mode{ModeNumber=2 IndexM=0 IndexN=0 KC2=0 PropagationState=Propagating Attenuation=0 PolarizationState=TM AffectsRefinement}}
  FloquetPort2: Floquet Port Faces=Region.face(-z) NumModes=2 DeembedDist=10mm Modes{Mode1{CharImp=Zpi} Mode2{CharImp=Zpi}} PhaseDelay=UseScanAngle Phi=0deg Theta=angle LatticeAVector{(4.895, 0, -10) -> (4.895, 4.895, -10)} LatticeBVector{(4.895, 0, -10) -> (0, 0, -10)} ModesList{Mode{ModeNumber=1 IndexM=0 IndexN=0 KC2=0 PropagationState=Propagating Attenuation=0 PolarizationState=TE AffectsRefinement} Mode{ModeNumber=2 IndexM=0 IndexN=0 KC2=0 PropagationState=Propagating Attenuation=0 PolarizationState=TM AffectsRefinement}}
setups:
  Setup2: HfssDriven Frequency=76.5GHz MaxDeltaS=0.02 MaximumPasses=5 MinimumPasses=1 MinimumConvergedPasses=1 PercentRefinement=30 BasisOrder=1 PortAccuracy=2 DrivenSolverType="Direct Solver"
    sweep Sweep: 75GHz to 78GHz step 0.03GHz; Type=Interpolating InterpTolerance=0.5 InterpMaxSolns=250 InterpUsePortImped=false PassivityErrorTolerance=0.0001
source amplitudes:
  FloquetPort1:1: 1W 0deg
  FloquetPort1:2, FloquetPort2:1, FloquetPort2:2: 0W 0deg
optimetrics:
  ParametricSetup1: Parametric Sim._Setups=[Setup2]
    sweep angle: LIN 0deg 40deg 10deg
output variables:
  AbsorbanceTM = 1-((mag(S(FloquetPort1:2,FloquetPort1:2)))^2 +(mag(S(FloquetPort2:2,FloquetPort1:2)))^2)
  Reflectance = (mag(S(FloquetPort1:1,FloquetPort1:1)))^2
  AbsorbanceTE = 1-((mag(S(FloquetPort1:1,FloquetPort1:1)))^2 +(mag(S(FloquetPort2:1,FloquetPort1:1)))^2)
reports:
  AbsorptionRef_angle: AbsorbanceTM, AbsorbanceTE vs Freq on Setup2 : Sweep [angle=all]

design Fabrication (HFSS, HFSS Modal Network, model units mm)
variables:
  Xsize = 5mm
  Ysize = 5mm
  H = 0.508mm
  angle = 0deg
geometry:
  Region [vacuum] = region(absolute_offset: +X=0mm, -X=0mm, +Y=0mm, -Y=0mm, +Z=10mm, -Z=10mm)
  conductor_1 [copper] = imported_body(C:/Users/jorge/AppData/Local/Temp/3288166017413669153..x_t)
  conductor_1.thicken(0.035mm)
  substrate_6 [Rogers RT/duroid 5880 (tm)] = imported_body(C:/Users/jorge/AppData/Local/Temp/3288166017413669153..x_t)
  substrate_6.thicken(0.508mm)
  substrate_7 = imported_body(C:/Users/jorge/AppData/Local/Temp/3288166017413669153..x_t)
  [conductor_1, substrate_6, substrate_7].move(0mm, 4.8939238mm, 0mm)
  substrate_7_1..substrate_7_14 = substrate_7.duplicate_along_line(step=(0mm, 4.8939238mm, 0mm), total=15)
  conductor_1_1..conductor_1_14 [copper] = conductor_1.duplicate_along_line(step=(0mm, 4.8939238mm, 0mm), total=15)
  substrate_6_1..substrate_6_14 = substrate_6.duplicate_along_line(step=(0mm, 4.8939238mm, 0mm), total=15)
  conductor_1_15..conductor_1_28 [copper] = conductor_1.duplicate_along_line(step=(4.8936738mm, 0.00025mm, 0mm), total=15)
  substrate_6_15..substrate_6_28 = substrate_6.duplicate_along_line(step=(4.8936738mm, 0.00025mm, 0mm), total=15)
  substrate_7_28, substrate_7_15..substrate_7_27 = substrate_7.duplicate_along_line(step=(4.8936738mm, 0.00025mm, 0mm), total=15)
  substrate_7_1_1..substrate_7_1_14 = substrate_7_1.duplicate_along_line(step=(4.8936738mm, 0.00025mm, 0mm), total=15)
  substrate_7_2_1..substrate_7_2_14 = substrate_7_2.duplicate_along_line(step=(4.8936738mm, 0.00025mm, 0mm), total=15)
  substrate_7_3_1..substrate_7_3_14 = substrate_7_3.duplicate_along_line(step=(4.8936738mm, 0.00025mm, 0mm), total=15)
  substrate_7_4_1..substrate_7_4_14 = substrate_7_4.duplicate_along_line(step=(4.8936738mm, 0.00025mm, 0mm), total=15)
  substrate_7_5_1..substrate_7_5_14 = substrate_7_5.duplicate_along_line(step=(4.8936738mm, 0.00025mm, 0mm), total=15)
  substrate_7_6_1..substrate_7_6_14 = substrate_7_6.duplicate_along_line(step=(4.8936738mm, 0.00025mm, 0mm), total=15)
  substrate_7_7_1..substrate_7_7_14 = substrate_7_7.duplicate_along_line(step=(4.8936738mm, 0.00025mm, 0mm), total=15)
  substrate_7_8_1..substrate_7_8_14 = substrate_7_8.duplicate_along_line(step=(4.8936738mm, 0.00025mm, 0mm), total=15)
  substrate_7_9_1..substrate_7_9_14 = substrate_7_9.duplicate_along_line(step=(4.8936738mm, 0.00025mm, 0mm), total=15)
  substrate_7_10_1..substrate_7_10_14 = substrate_7_10.duplicate_along_line(step=(4.8936738mm, 0.00025mm, 0mm), total=15)
  substrate_7_11_1..substrate_7_11_14 = substrate_7_11.duplicate_along_line(step=(4.8936738mm, 0.00025mm, 0mm), total=15)
  substrate_7_12_1..substrate_7_12_14 = substrate_7_12.duplicate_along_line(step=(4.8936738mm, 0.00025mm, 0mm), total=15)
  substrate_7_13_1..substrate_7_13_14 = substrate_7_13.duplicate_along_line(step=(4.8936738mm, 0.00025mm, 0mm), total=15)
  substrate_7_14_1..substrate_7_14_14 = substrate_7_14.duplicate_along_line(step=(4.8936738mm, 0.00025mm, 0mm), total=15)
  conductor_1_1_1..conductor_1_1_14 [copper] = conductor_1_1.duplicate_along_line(step=(4.8936738mm, 0.00025mm, 0mm), total=15)
  conductor_1_2_1..conductor_1_2_14 [copper] = conductor_1_2.duplicate_along_line(step=(4.8936738mm, 0.00025mm, 0mm), total=15)
  conductor_1_3_1..conductor_1_3_14 [copper] = conductor_1_3.duplicate_along_line(step=(4.8936738mm, 0.00025mm, 0mm), total=15)
  conductor_1_4_1..conductor_1_4_14 [copper] = conductor_1_4.duplicate_along_line(step=(4.8936738mm, 0.00025mm, 0mm), total=15)
  conductor_1_5_1..conductor_1_5_14 [copper] = conductor_1_5.duplicate_along_line(step=(4.8936738mm, 0.00025mm, 0mm), total=15)
  conductor_1_6_1..conductor_1_6_14 [copper] = conductor_1_6.duplicate_along_line(step=(4.8936738mm, 0.00025mm, 0mm), total=15)
  conductor_1_7_1..conductor_1_7_14 [copper] = conductor_1_7.duplicate_along_line(step=(4.8936738mm, 0.00025mm, 0mm), total=15)
  conductor_1_8_1..conductor_1_8_14 [copper] = conductor_1_8.duplicate_along_line(step=(4.8936738mm, 0.00025mm, 0mm), total=15)
  conductor_1_9_1..conductor_1_9_14 [copper] = conductor_1_9.duplicate_along_line(step=(4.8936738mm, 0.00025mm, 0mm), total=15)
  conductor_1_10_1..conductor_1_10_14 [copper] = conductor_1_10.duplicate_along_line(step=(4.8936738mm, 0.00025mm, 0mm), total=15)
  conductor_1_11_1..conductor_1_11_14 [copper] = conductor_1_11.duplicate_along_line(step=(4.8936738mm, 0.00025mm, 0mm), total=15)
  conductor_1_12_1..conductor_1_12_14 [copper] = conductor_1_12.duplicate_along_line(step=(4.8936738mm, 0.00025mm, 0mm), total=15)
  conductor_1_13_1..conductor_1_13_14 [copper] = conductor_1_13.duplicate_along_line(step=(4.8936738mm, 0.00025mm, 0mm), total=15)
  conductor_1_14_1..conductor_1_14_14 [copper] = conductor_1_14.duplicate_along_line(step=(4.8936738mm, 0.00025mm, 0mm), total=15)
  substrate_6_1_1..substrate_6_1_14 = substrate_6_1.duplicate_along_line(step=(4.8936738mm, 0.00025mm, 0mm), total=15)
  substrate_6_2_1..substrate_6_2_14 = substrate_6_2.duplicate_along_line(step=(4.8936738mm, 0.00025mm, 0mm), total=15)
  substrate_6_3_1..substrate_6_3_14 = substrate_6_3.duplicate_along_line(step=(4.8936738mm, 0.00025mm, 0mm), total=15)
  substrate_6_4_1..substrate_6_4_14 = substrate_6_4.duplicate_along_line(step=(4.8936738mm, 0.00025mm, 0mm), total=15)
  substrate_6_5_1..substrate_6_5_14 = substrate_6_5.duplicate_along_line(step=(4.8936738mm, 0.00025mm, 0mm), total=15)
  substrate_6_6_1..substrate_6_6_14 = substrate_6_6.duplicate_along_line(step=(4.8936738mm, 0.00025mm, 0mm), total=15)
  substrate_6_7_1..substrate_6_7_14 = substrate_6_7.duplicate_along_line(step=(4.8936738mm, 0.00025mm, 0mm), total=15)
  substrate_6_8_1..substrate_6_8_14 = substrate_6_8.duplicate_along_line(step=(4.8936738mm, 0.00025mm, 0mm), total=15)
  substrate_6_9_1..substrate_6_9_14 = substrate_6_9.duplicate_along_line(step=(4.8936738mm, 0.00025mm, 0mm), total=15)
  substrate_6_10_1..substrate_6_10_14 = substrate_6_10.duplicate_along_line(step=(4.8936738mm, 0.00025mm, 0mm), total=15)
  substrate_6_11_1..substrate_6_11_14 = substrate_6_11.duplicate_along_line(step=(4.8936738mm, 0.00025mm, 0mm), total=15)
  substrate_6_12_1..substrate_6_12_14 = substrate_6_12.duplicate_along_line(step=(4.8936738mm, 0.00025mm, 0mm), total=15)
  substrate_6_13_1..substrate_6_13_14 = substrate_6_13.duplicate_along_line(step=(4.8936738mm, 0.00025mm, 0mm), total=15)
  substrate_6_14_1..substrate_6_14_14 = substrate_6_14.duplicate_along_line(step=(4.8936738mm, 0.00025mm, 0mm), total=15)
  substrate_6.unite(substrate_6_1, substrate_6_1_1..substrate_6_1_14, substrate_6_2, substrate_6_2_1..substrate_6_2_14, substrate_6_3, substrate_6_3_1..substrate_6_3_14, substrate_6_4, substrate_6_4_1..substrate_6_4_14, substrate_6_5, substrate_6_5_1..substrate_6_5_14, substrate_6_6, substrate_6_6_1..substrate_6_6_14, substrate_6_7, substrate_6_7_1..substrate_6_7_14, substrate_6_8, substrate_6_8_1..substrate_6_8_14, substrate_6_9, substrate_6_9_1..substrate_6_9_14, substrate_6_10, substrate_6_10_1..substrate_6_10_14, substrate_6_11, substrate_6_11_1..substrate_6_11_14, substrate_6_12, substrate_6_12_1..substrate_6_12_14, substrate_6_13, substrate_6_13_1..substrate_6_13_14, substrate_6_14, substrate_6_14_1..substrate_6_14_14, substrate_6_15..substrate_6_28)
  substrate_7_28.unite(substrate_7, substrate_7_1, substrate_7_1_1..substrate_7_1_14, substrate_7_2, substrate_7_2_1..substrate_7_2_14, substrate_7_3, substrate_7_3_1..substrate_7_3_14, substrate_7_4, substrate_7_4_1..substrate_7_4_14, substrate_7_5, substrate_7_5_1..substrate_7_5_14, substrate_7_6, substrate_7_6_1..substrate_7_6_14, substrate_7_7, substrate_7_7_1..substrate_7_7_14, substrate_7_8, substrate_7_8_1..substrate_7_8_14, substrate_7_9, substrate_7_9_1..substrate_7_9_14, substrate_7_10, substrate_7_10_1..substrate_7_10_14, substrate_7_11, substrate_7_11_1..substrate_7_11_14, substrate_7_12, substrate_7_12_1..substrate_7_12_14, substrate_7_13, substrate_7_13_1..substrate_7_13_14, substrate_7_14, substrate_7_14_1..substrate_7_14_14, substrate_7_15..substrate_7_27)
boundaries and excitations:
  Primary1: Primary Faces=Region.face(+x) CoordSysVector{(73.405107, 0.00025, 10.543) -> (73.405107, 73.412607, 10.543)}
  Primary2: Primary Faces=Region.face(+y) CoordSysVector{(73.405107, 73.412607, 10.543) -> (-0.00025, 73.412607, 10.543)}
  Secondary1: Secondary Faces=Region.face(-y) CoordSysVector{(73.405107, 0.00025, 10.543) -> (-0.00025, 0.00025, 10.543)} ReverseV primary=Primary2 PhaseDelay=UseScanAngle Phi=0deg Theta=angle
  Secondary2: Secondary Faces=Region.face(-x) CoordSysVector{(-0.00025, 0.00025, 10.543) -> (-0.00025, 73.412607, 10.543)} ReverseV primary=Primary1 PhaseDelay=UseScanAngle Phi=0deg Theta=angle
  PerfE211: Perfect E Objects=substrate_7_28
  FloquetPort1: Floquet Port Faces=Region.face(+z) NumModes=2 DeembedDist=10mm Modes{Mode1{CharImp=Zpi} Mode2{CharImp=Zpi}} PhaseDelay=UseScanAngle Phi=0deg Theta=angle LatticeAVector{(73.405107, 0.00025, 10.543) -> (73.405107, 73.412607, 10.543)} LatticeBVector{(73.405107, 0.00025, 10.543) -> (-0.00025, 0.00025, 10.543)} ModesList{Mode{ModeNumber=1 IndexM=0 IndexN=0 KC2=0 PropagationState=Propagating Attenuation=0 PolarizationState=TE AffectsRefinement} Mode{ModeNumber=2 IndexM=0 IndexN=0 KC2=0 PropagationState=Propagating Attenuation=0 PolarizationState=TM AffectsRefinement}}
  FloquetPort2: Floquet Port Faces=Region.face(-z) NumModes=2 DeembedDist=10mm Modes{Mode1{CharImp=Zpi} Mode2{CharImp=Zpi}} PhaseDelay=UseScanAngle Phi=0deg Theta=angle LatticeAVector{(73.405107, 0.00025, -10) -> (73.405107, 73.412607, -10)} LatticeBVector{(73.405107, 0.00025, -10) -> (-0.00025, 0.00025, -10)} ModesList{Mode{ModeNumber=1 IndexM=0 IndexN=0 KC2=0 PropagationState=Propagating Attenuation=0 PolarizationState=TE AffectsRefinement} Mode{ModeNumber=2 IndexM=0 IndexN=0 KC2=0 PropagationState=Propagating Attenuation=0 PolarizationState=TM AffectsRefinement}}
mesh:
  initial mesh: GlobalSurfApproximation{CurvedSurfaceApproxChoice=UseSlider SliderMeshSettings=3} GlobalModelRes{DefeatureLength=0.08mm} DynamicSurfaceResolution
setups:
  Setup1: HfssDriven Frequency=76.5GHz MaxDeltaS=0.02 MaximumPasses=10 MinimumPasses=3 MinimumConvergedPasses=2 PercentRefinement=30 BasisOrder=1 PortAccuracy=2 DrivenSolverType="Direct Solver"
    sweep Sweep: 75GHz to 78GHz step 0.03GHz; Type=Interpolating InterpTolerance=0.5 InterpMaxSolns=250 InterpUsePortImped=false PassivityErrorTolerance=0.0001
source amplitudes:
  FloquetPort1:1: 1W 0deg
  FloquetPort1:2, FloquetPort2:1, FloquetPort2:2: 0W 0deg
optimetrics:
  ParametricSetup1: Parametric Sim._Setups=[Setup1]
    sweep angle: LIN 0deg 40deg 10deg
output variables:
  transmittance = (mag(S(FloquetPort2:1,FloquetPort1:1)))^2
  transmittanceTM = (mag(S(FloquetPort2:2,FloquetPort1:2)))^2
  ReflectanceTE = (mag(S(FloquetPort1:1,FloquetPort1:1)))^2
  ReflectanceTM = (mag(S(FloquetPort1:2,FloquetPort1:2)))^2
  AbsorbanceTE = 1-((mag(S(FloquetPort1:1,FloquetPort1:1)))^2 +(mag(S(FloquetPort2:1,FloquetPort1:1)))^2)
  AbsorbanceTM = 1-((mag(S(FloquetPort1:2,FloquetPort1:2)))^2 +(mag(S(FloquetPort2:2,FloquetPort1:2)))^2)
reports:
  Reflectance: ReflectanceTE, ReflectanceTM vs Freq on Setup1 : Sweep
  AbsorptionGen_angle: AbsorbanceTE, AbsorbanceTM vs Freq on Setup1 : Sweep [angle=all]
