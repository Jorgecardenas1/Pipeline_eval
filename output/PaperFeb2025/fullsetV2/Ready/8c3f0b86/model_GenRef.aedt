# Ansys Electronics Desktop project, version 2023.2
materials:
  vacuum: permittivity=1
  Rogers RT/duroid 5880 (tm): permittivity=2.2 dielectric_loss_tangent=0.0009
  pec: conductivity=1e+30
  copper: permeability=0.999991 conductivity=58000000

design HFSSDesign1 (HFSS, HFSS Modal Network, model units mm)
variables:
  Xsize = 5mm
  Ysize = 5mm
  H = 0.508mm
  angle = 15deg
geometry:
  Region [vacuum] = region(absolute_offset: +X=0mm, -X=0mm, +Y=0mm, -Y=0mm, +Z=10mm, -Z=10mm)
  conductor_1 [copper] = imported_body(C:/Users/jorge/AppData/Local/Temp/20E31207217410143293..x_t)
  conductor_1.thicken(0.035mm)
  substrate_9 [Rogers RT/duroid 5880 (tm)] = imported_body(C:/Users/jorge/AppData/Local/Temp/20E31207217410143293..x_t)
  substrate_9.thicken(0.508mm)
  substrate_10 = imported_body(C:/Users/jorge/AppData/Local/Temp/20E31207217410143293..x_t)
  [conductor_1, substrate_9, substrate_10].move(0mm, 5.0356465mm, 0mm)
boundaries and excitations:
  Primary1: Primary Faces=Region.face(+x) CoordSysVector{(5.0353965, 0.00025, 10.543) -> (5.0353965, 5.0358965, 10.543)}
  Primary2: Primary Faces=Region.face(+y) CoordSysVector{(5.0353965, 5.0358965, 10.543) -> (-0.00025, 5.0358965, 10.543)}
  Secondary1: Secondary Faces=Region.face(-y) CoordSysVector{(5.0353965, 0.00025, 10.543) -> (-0.00025, 0.00025, 10.543)} ReverseV primary=Primary2 PhaseDelay=UseScanAngle Phi=0deg Theta=angle
  Secondary2: Secondary Faces=Region.face(-x) CoordSysVector{(-0.00025, 0.00025, 10.543) -> (-0.00025, 5.0358965, 10.543)} ReverseV primary=Primary1 PhaseDelay=UseScanAngle Phi=0deg Theta=angle
  PerfE1: Perfect E Objects=substrate_10
  FloquetPort1: Floquet Port Faces=Region.face(+z) NumModes=2 DeembedDist=10mm Modes{Mode1{CharImp=Zpi} Mode2{CharImp=Zpi}} PhaseDelay=UseScanAngle Phi=0deg Theta=angle LatticeAVector{(5.0353965, 0.00025, 10.543) -> (5.0353965, 5.0358965, 10.543)} LatticeBVector{(5.0353965, 0.00025, 10.543) -> (-0.00025, 0.00025, 10.543)} ModesList{Mode{ModeNumber=1 IndexM=0 IndexN=0 KC2=0 PropagationState=Propagating Attenuation=0 PolarizationState=TE AffectsRefinement} Mode{ModeNumber=2 IndexM=0 IndexN=0 KC2=0 PropagationState=Propagating Attenuation=0 PolarizationState=TM AffectsRefinement}}
  FloquetPort2: Floquet Port Faces=Region.face(-z) NumModes=2 DeembedDist=10mm Modes{Mode1{CharImp=Zpi} Mode2{CharImp=Zpi}} PhaseDelay=UseScanAngle Phi=0deg Theta=angle LatticeAVector{(5.0353965, 0.00025, -10) -> (5.0353965, 5.0358965, -10)} LatticeBVector{(5.0353965, 0.00025, -10) -> (-0.00025, 0.00025, -10)} ModesList{Mode{ModeNumber=1 IndexM=0 IndexN=0 KC2=0 PropagationState=Propagating Attenuation=0 PolarizationState=TE AffectsRefinement} Mode{ModeNumber=2 IndexM=0 IndexN=0 KC2=0 PropagationState=Propagating Attenuation=0 PolarizationState=TM AffectsRefinement}}
mesh:
  initial mesh: GlobalSurfApproximation{CurvedSurfaceApproxChoice=UseSlider SliderMeshSettings=3} GlobalModelRes{DefeatureLength=0.08mm} DynamicSurfaceResolution
setups:
  Setup1: HfssDriven Frequency=76.5GHz MaxDeltaS=0.02 MaximumPasses=10 MinimumPasses=3 MinimumConvergedPasses=2 PercentRefinement=30 BasisOrder=1 PortAccuracy=2 DrivenSolverType="Direct Solver"
    sweep Sweep: 75GHz to 78GHz step 0.03GHz; Type=Interpolating InterpTolerance=0.5 InterpMaxSolns=250 InterpUsePortImped=false PassivityErrorTolerance=0.0001
source amplitudes:
  FloquetPort1:1: 1W 0deg
  FloquetPort1:2, FloquetPort2:1, FloquetPort2:2: 0W 0deg
optimetrics:
  ParametricSetup1: Parametric Sim._Setups=[Setup1]
    sweep angle: LIN 0deg 40deg 10deg
output variables:
  transmittance = (mag(S(FloquetPort2:1,FloquetPort1:1)))^2
  transmittanceTM = (mag(S(FloquetPort2:2,FloquetPort1:2)))^2
  ReflectanceTE = (mag(S(FloquetPort1:1,FloquetPort1:1)))^2
  ReflectanceTM = (mag(S(FloquetPort1:2,FloquetPort1:2)))^2
  AbsorbanceTE = 1-((mag(S(FloquetPort1:1,FloquetPort1:1)))^2 +(mag(S(FloquetPort2:1,FloquetPort1:1)))^2)
  AbsorbanceTM = 1-((mag(S(FloquetPort1:2,FloquetPort1:2)))^2 +(mag(S(FloquetPort2:2,FloquetPort1:2)))^2)
reports:
  Reflectance: ReflectanceTE, ReflectanceTM vs Freq on Setup1 : Sweep
  AbsorptionGen_angle: AbsorbanceTE, AbsorbanceTM vs Freq on Setup1 : Sweep [angle=all]

design HFSSDesign3 (HFSS, HFSS Modal Network, model units mm)
variables:
  margin = 1mm
  H = 0.508mm
  wArm = 1.2mm
  lArm = 3.52mm
  cellSize = 5mm
  Xsize = cellSize
  Ysize = cellSize
  angle = 40deg
  parameters = [1.206, 3.266, 0.035, 0.508, 5.025] mm
geometry:
  Rectangle1 = rectangle(corner=(0mm, 0mm, 0mm), x_size=parameters[4], y_size=parameters[4])
  Box1 [Rogers RT/duroid 5880 (tm)] = box(corner=(0mm, 0mm, 0mm), size=(parameters[4], parameters[4], H))
  Region [vacuum] = region(absolute_offset: +X=0mm, -X=0mm, +Y=0mm, -Y=0mm, +Z=10mm, -Z=10mm)
  Box2 [pec] = box(corner=(parameters[4]/2 -parameters[0] /2, parameters[4]/2 - parameters[1]/2, H), size=(parameters[0], parameters[1], parameters[2]))
  Box3 = box(corner=(parameters[4]/2 -parameters[1]/2, parameters[4]/2-parameters[0]/2, H), size=(parameters[1], parameters[0], parameters[2]))
  Box2.unite(Box3)
boundaries and excitations:
  PerfE1: Perfect E Objects=Rectangle1
  Primary1: Primary Faces=Region.face(+x) CoordSysVector{(5.025, 0, 10.543) -> (5.025, 5.025, 10.543)}
  Primary2: Primary Faces=Region.face(+y) CoordSysVector{(5.025, 5.025, 10.543) -> (0, 5.025, 10.543)}
  Secondary1: Secondary Faces=Region.face(-y) CoordSysVector{(5.025, 0, 10.543) -> (0, 0, 10.543)} ReverseV primary=Primary2 PhaseDelay=UseScanAngle Phi=0deg Theta=angle
  Secondary2: Secondary Faces=Region.face(-x) CoordSysVector{(0, 0, 10.543) -> (0, 5.025, 10.543)} ReverseV primary=Primary1 PhaseDelay=UseScanAngle Phi=0deg Theta=angle
  FloquetPort1: Floquet Port Faces=Region.face(+z) NumModes=2 DeembedDist=10mm Modes{Mode1{CharImp=Zpi} Mode2{CharImp=Zpi}} PhaseDelay=UseScanAngle Phi=0deg Theta=angle LatticeAVector{(5.025, 0, 10.543) -> (5.025, 5.025, 10.543)} LatticeBVector{(5.025, 0, 10.543) -> (0, 0, 10.543)} ModesList{Mode{ModeNumber=1 IndexM=0 IndexN=0 KC2=0 PropagationState=Propagating Attenuation=0 PolarizationState=TE AffectsRefinement} Mode{ModeNumber=2 IndexM=0 IndexN=0 KC2=0 PropagationState=Propagating Attenuation=0 PolarizationState=TM AffectsRefinement}}
  FloquetPort2: Floquet Port Faces=Region.face(-z) NumModes=2 DeembedDist=10mm Modes{Mode1{CharImp=Zpi} Mode2{CharImp=Zpi}} PhaseDelay=UseScanAngle Phi=0deg Theta=angle LatticeAVector{(5.025, 0, -10) -> (5.025, 5.025, -10)} LatticeBVector{(5.025, 0, -10) -> (0, 0, -10)} ModesList{Mode{ModeNumber=1 IndexM=0 IndexN=0 KC2=0 PropagationState=Propagating Attenuation=0 PolarizationState=TE AffectsRefinement} Mode{ModeNumber=2 IndexM=0 IndexN=0 KC2=0 PropagationState=Propagating Attenuation=0 PolarizationState=TM AffectsRefinement}}
setups:
  Setup1: HfssDriven Frequency=76.5GHz MaxDeltaS=0.02 MaximumPasses=5 MinimumPasses=1 MinimumConvergedPasses=1 PercentRefinement=30 BasisOrder=1 PortAccuracy=2 DrivenSolverType="Direct Solver"
    sweep Sweep: 75GHz to 78GHz step 0.03GHz; Type=Interpolating InterpTolerance=0.5 InterpMaxSolns=250 InterpUsePortImped=false PassivityErrorTolerance=0.0001
source amplitudes:
  FloquetPort1:1: 1W 0deg
  FloquetPort1:2, FloquetPort2:1, FloquetPort2:2: 0W 0deg
optimetrics:
  ParametricSetup1: Parametric Sim._Setups=[Setup1]
    sweep angle: LIN 0deg 40deg 10deg
output variables:
  AbsorbanceTE = 1-((mag(S(FloquetPort1:1,FloquetPort1:1)))^2 +(mag(S(FloquetPort2:1,FloquetPort1:1)))^2)
  AbsorbanceTM = 1-((mag(S(FloquetPort1:2,FloquetPort1:2)))^2 +(mag(S(FloquetPort2:2,FloquetPort1:2)))^2)
  Reflectance = (mag(S(FloquetPort1:1,FloquetPort1:1)))^2
reports:
  AbsorptionRef_angle: AbsorbanceTE, AbsorbanceTM vs Freq on Setup1 : Sweep [angle=all]
